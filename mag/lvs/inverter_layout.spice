* NGSPICE file created from inverter.ext - technology: gf180mcuD

.subckt pfet_03v3_H75YCY a_28_n226# a_n116_n179# w_n202_n404# a_n36_n318#
X0 a_28_n226# a_n36_n318# a_n116_n179# w_n202_n404# pfet_03v3 ad=1.06945p pd=5.88u as=1.06945p ps=5.88u w=2.5u l=0.28u
.ends

.subckt nfet_03v3_ZPKZMM a_n36_96# a_28_n124# a_n116_n107# VSUBS
X0 a_28_n124# a_n36_96# a_n116_n107# VSUBS nfet_03v3 ad=0.42895p pd=2.88u as=0.42895p ps=2.88u w=1u l=0.28u
.ends

.subckt inverter in vdd vss out
XM2 out vdd vdd in pfet_03v3_H75YCY
Xnfet_03v3_ZPKZMM_0 in out vss vss nfet_03v3_ZPKZMM
.ends
